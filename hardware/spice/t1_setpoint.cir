* 1. Rail voltage against the DAC, switch off, no load
.include rail.inc
Vdac dac 0 0
Vben buck_en 0 3.3
Vsw  swen 0 0
Vdis dis 0 0
Rstrap strap 0 1m
.control
foreach vd 0 0.1 0.6 1.65 2.3 3.0 3.3
  alter Vdac dc = $vd
  op
  print v(vraw)
end
.endc
.end
