* 2. Over-voltage comparator: force VDUT_RAW, switch requested on.
*    strap open (3.3 V cartridge or none) and strap grounded (5 V cartridge)
.include rail.inc
Vdac dac 0 0
Vben buck_en 0 0
Vf   vraw 0 3
Vsw  swen 0 3.3
Vdis dis 0 0
Rstrap strap 0 1G
.control
dc Vf 2 7 0.002
meas dc trip_open  when v(ovpn)=1.5 fall=1
meas dc below_open find v(vdut) at=3.7
meas dc above_open find v(vdut) at=4.0
alter Rstrap = 1m
dc Vf 2 7 0.002
meas dc trip_5v   when v(ovpn)=1.5 fall=1
meas dc below_5v  find v(vdut) at=5.7
meas dc above_5v  find v(vdut) at=6.0
meas dc ovpn_on   find v(ovpn) at=5.0
.endc
.end
