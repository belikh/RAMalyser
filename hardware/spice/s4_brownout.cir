* 4. The USB supply is pulled with the rail on. The input capacitors run
*    down through the regulators; the 3.3 V rail, the DAC reference and
*    the comparator reference go with it. vset, dacv, rl and strap5 are
*    set by run_sequence.sh (a 5 V cartridge at 5 V and 1 A, then a 3.3 V
*    cartridge at 3.3 V and 0.5 A).
* Gear integration: the regulators are constant-power loads on a falling
* input, which the default method does not get through.
.options method=gear
.param strap5=1
.include rail_seq.inc
.include seq.inc
.param dacv=0.6
.param rl=5
.param vset=5
Vsrc src 0 9
Vcut cut 0 PWL(0 1 80m 1 80.01m 0)
.model SWIN SW(VT=0.5 VH=0 RON=50m ROFF=100MEG)
Sin  src vbus cut 0 SWIN
Vplug plug 0 1
Vdacf dacf 0 {dacv/3.3}
Rload vcart 0 {rl}
Vfen fw_en 0 PWL(0 0 20m 0 20.001m 3.3)
Vfsw fw_sw 0 PWL(0 0 30m 0 30.001m 3.3)
Vfdis fw_dis 0 0
.control
tran 5u 400m
meas tran vcart_on   find v(vcart) at=79m
meas tran vcart_max  max v(vcart) from=80m to=400m
meas tran vraw_max   max v(vraw) from=80m to=400m
meas tran t_33_low   when v(v33)=2.9 fall=1 td=80m
meas tran vcart_at33 find v(vcart) when v(v33)=2.9 fall=1 td=80m
meas tran t_trip     when v(ovpn)=1.5 fall=1 td=80m
meas tran t_dut_low  when v(vcart)=0.5 fall=1 td=80m
meas tran vcart_end  find v(vcart) at=399m
meas tran v33_end    find v(v33) at=399m
.endc
.end
